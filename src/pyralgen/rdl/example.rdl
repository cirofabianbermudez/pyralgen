//=============================================================================
// [Filename]       ral.rdl
// [Project]        IGNITE64
// [Author]         Ciro Bermudez - cirofabian.bermudezmarquez@ba.infn.it
// [Language]       SystemRDL 2.0 (Register Description Language)
// [Created]        Nov 2024
// [Modified]       -
// [Description]    SystemRDL file to describe and manage the registers inside
//                  Mattonella
// [Notes]          This file is the input for PeakRDL-uvm
//                  Use this command to generate the UVM register model
//                  ./rdl_utils.py -rdl ral_mattonella.rdl -out mattonella_regs.sv
//                  Consider using (UDP) User Defined Properties
// [Status]         -
// [Revisions]      -
//=============================================================================

// ================================= DEFAULTS =================================
default regwidth = 8;
default sw = rw;
default hw = r;

// ================================= TEMPLATES =================================

// ==============================================================================
// Name:    SET_TDC_DCO1_XX
// Range:   [0x00 to 0x3F] or [0 to 63]
// Default: 8'h1F or 8'b0001_1111
// ==============================================================================
reg tdc_reg {
  name = "Pixel settings";
  desc = "There registers are used to Set/Get the values related to the single pixel";
  field {
    name = "Front End on Bit";
    desc = "Set/Get if FE is switched ON/OFF

            - 0: FE is powered OFF.
            - 1: FE is powered ON.";
  } feon[7:7] = 1'b0;
  field {
    name = "Pixel On Bit";
    desc = "Set/Get TDC pixel input

            - 0: TDC pixel is forced to ignore any input. Also the Calibration is skipped.
            - 1: TDC pixel is connected to input. Also the Calibration is performed.";
  } pxon[6:6] = 1'b0;
  field {
    name = "Adjust Bits";
    desc = "Set/Get the coarse delay DC01

            - 0: Max delay, max DCO period.
            - 1,2: DCO Period is reduced of about 48ps. Code 1 and 2 are equivalent.
            - 3: DCO Period is reduced by a further 48ps approximately. ";
  } adj1[5:4] = 2'b01;
  field {
    name = "Control Bits";
    desc = "Set/Get the fine delay for DCO1

           - 0: Max delay, max DCO period.
           - 1->14: DCO Period is reduced of about 2.5ps.
           - 15: Equivalent to code 14. ";
  } ctrl1[3:0] = 4'b1111;
};

// ==============================================================================
// Name:    SET_TDC_CTRL_ALL
// Range:   [0x40] or [64]
// Default: 8'h10 or 8'b0001_0000
// ==============================================================================
reg tdc_ctrl_reg {
  name = "";
  desc = "This register is used to Set/get the values related the TDC global settings.";
  field {
    desc = "Set/Get the Double Edge more for TOT/calibration counter";
  } endetot[7:7] = 1'b0;
  field {
    desc = "Set/Get TDCs ON/OFF";
  } tdcon[6:6] = 1'b0;
  field {
    desc = "Set/Get the coarse delay for DCO0";
  } adj0[5:4] = 2'b01;
  field {
    desc = "Set/Get the fine delay for DCO0";
  } ctrl0[3:0] = 4'b0000;
};

// ==============================================================================
// Name:    SET_TDC_TPsel_X
// Range:   [0x41 to 0x42] or [65 to 66]
// Default: 8'h00 or 8'b0000_0000
// ==============================================================================
reg tdc_tpsel_reg {
  name = "";
  desc = "";
  field {
    desc = "Channel Mode";
  } ch_mode[7:6] = 2'b00;
  field {
    desc = "Channel selector";
  } ch_sel[5:0] = 6'b00_0000;
};

// ==============================================================================
// Name:    SET_AFE_TDC_GLOBAL
// Range:   [0x43] or [67]
// Default: 8'h83 or 8'b1000_0011
// ==============================================================================
reg afe_tdc_global_reg {
  name = "";
  desc = "";
  field {
    desc = "";
  } con_pad[7:7] = 1'b1;
  field {
    desc = "";
  } en_p_vth[6:6] = 1'b0;
  field {
    desc = "";
  } en_p_vldo[5:5] = 1'b0;
  field {
    desc = "";
  } en_p_vfb[4:4] = 1'b0;
  field {
    desc = "";
  } entimeout[3:3] = 1'b0;
  field {
    desc = "";
  } calmode[2:2] = 1'b0;
  field {
    desc = "";
  } selcaltime[1:0] = 2'b11;
};

// ==============================================================================
// Name:    SET_AFE_GLOBAL_0
// Range:   [0x44] or [68]
// Default: 8'h00 or 8'b0000_0000
// ==============================================================================
reg afe_global0_reg {
  name = "";
  desc = "";
  field {
    desc = "";
  } afe_lb[7:7] = 1'b0;
  field {
    desc = "";
  } afe_auto[6:6] = 1'b0;
  field {
    desc = "";
  } dac_idisc[5:3] = 3'b00;
  field {
    desc = "";
  } dac_icsa[2:0] = 3'b00;
};

// ==============================================================================
// Name:    SET_AFE_GLOBAL_1
// Range:   [0x45] or [69]
// Default: 8'h00 or 8'b0000_0000
// ==============================================================================
reg afe_global1_reg {
  name = "";
  desc = "";
  field {
    desc = "";
  } ext_dc[7:7] = 1'b0;
  field {
    desc = "";
  } en_p_vinj[6:6] = 1'b0;
  field {
    desc = "";
  } sel_vinjmux[5:3] = 3'b000;
  field {
    desc = "";
  } dac_ikrum[2:0] = 3'b000;
};

// ==============================================================================
// Name:    SET_DAC_VTH_H
// Range:   [0x46] or [70]
// Default: 8'h7F or 8'b0111_1111
// ==============================================================================
reg dac_vth_h_reg {
  name = "";
  desc = "";
  field {
    desc = "";
  } en_dac[7:7] = 1'b0;
  field {
    desc = "";
  } dac_vth_h[6:0] = 7'b111_1111;
};

// ==============================================================================
// Name:    SET_DAC_VTH_L
// Range:   [0x47] or [71]
// Default: 8'h7F or 8'b0111_1111
// ==============================================================================
reg dac_vth_l_reg {
  name = "";
  desc = "";
  field {
    desc = "";
  } en_dac[7:7] = 1'b0;
  field {
    desc = "";
  } dac_vth_l[6:0] = 7'b111_1111;
};

// ==============================================================================
// Name:    SET_DAC_VINJ_H
// Range:   [0x48] or [72]
// Default: 8'h00 or 8'b0000_0000
// ==============================================================================
reg dac_vinj_h_reg {
  name = "";
  desc = "";
  field {
    desc = "";
  } en_dac[7:7] = 1'b0;
  field {
    desc = "";
  } dac_vinj_h[6:0] = 7'b000_0000;
};

// ==============================================================================
// Name:    SET_DAC_VINJ_L 
// Range:   [0x49] or [73]
// Default: 8'h00 or 8'b0000_0000
// ==============================================================================
reg dac_vinj_l_reg {
  name = "";
  desc = "";
  field {
    desc = "";
  } en_dac[7:7] = 1'b0;
  field {
    desc = "";
  } dac_vinj_l[6:0] = 7'b000_0000;
};

// ==============================================================================
// Name:    SET_DAC_VLDO
// Range:   [0x4A] or [74]
// Default: 8'h3F or 8'b0011_1111
// ==============================================================================
reg dac_vldo_reg {
  name = "";
  desc = "";
  field {
    desc = "";
  } en_dac[7:7] = 1'b0;
  field {
    desc = "";
  } dac_vldo[6:0] = 7'b011_1111;
};

// ==============================================================================
// Name:    SET_DAC_VFB
// Range:   [0x4B] or [75]
// Default: 8'h3F or 8'b0011_1111
// ==============================================================================
reg dac_vfb_reg {
  name = "";
  desc = "";
  field {
    desc = "";
  } en_dac[7:7] = 1'b0;
  field {
    desc = "";
  } dac_vfb[6:0] = 7'b011_1111;
};

// ==============================================================================
// Name:    SET_FTDAC_(XX+1)_XX
// Range:   [0x4C to 0x6B] or [76 to 107]
// Default: 8'hFF or 8'b1111_1111
// ==============================================================================
reg ftdac_reg {
  name = "";
  desc = "";
  field {
    desc = "FT DAC 1";
  } ft_dac1[7:4] = 4'b1111;
  field {
    desc = "FT DAC 0";
  } ft_dac0[3:0] = 4'b1111;
};

// ==============================================================================
// Name:    COMMAND
// Range:   [0x70] or [112]
// Default: 8'h00 or 8'b0000_0000
// ==============================================================================
reg cmd_reg {
  name = "";
  desc = "";
  field {
    desc = "DAQres";
  } daqres[7:7] = 1'b0;
  field {
    desc = "Empty";
  } empty[6:5] = 2'b00;
  field {
    desc = "CalSelDco";
  } calseldco[4:4] = 1'b0;
  field {
    desc = "dcoC_G3";
  } dcoc_g3[3:3] = 1'b0;
  field {
    desc = "dcoC_G2";
  } dcoc_g2[2:2] = 1'b0;
  field {
    desc = "dcoC_G1";
  } dcoc_g1[1:1] = 1'b0;
  field {
    desc = "dcoC_G0";
  } dcoc_g0[0:0] = 1'b0;
};

// ================================ ADDRESS MAP ================================

addrmap mattonella_reg_block {
    name = "Mattonella registers";
    desc = "This is the SystemRDL description of Mattonella";

    // Instantiate the TDC registers
    tdc_reg              SET_TDC_DCO1_00     @ 00;
    tdc_reg              SET_TDC_DCO1_01     @ 01;
    tdc_reg              SET_TDC_DCO1_02     @ 02;
    tdc_reg              SET_TDC_DCO1_03     @ 03;
    tdc_reg              SET_TDC_DCO1_04     @ 04;
    tdc_reg              SET_TDC_DCO1_05     @ 05;
    tdc_reg              SET_TDC_DCO1_06     @ 06;
    tdc_reg              SET_TDC_DCO1_07     @ 07;
    tdc_reg              SET_TDC_DCO1_08     @ 08;
    tdc_reg              SET_TDC_DCO1_09     @ 09;
    tdc_reg              SET_TDC_DCO1_10     @ 10;
    tdc_reg              SET_TDC_DCO1_11     @ 11;
    tdc_reg              SET_TDC_DCO1_12     @ 12;
    tdc_reg              SET_TDC_DCO1_13     @ 13;
    tdc_reg              SET_TDC_DCO1_14     @ 14;
    tdc_reg              SET_TDC_DCO1_15     @ 15;
    tdc_reg              SET_TDC_DCO1_16     @ 16;
    tdc_reg              SET_TDC_DCO1_17     @ 17;
    tdc_reg              SET_TDC_DCO1_18     @ 18;
    tdc_reg              SET_TDC_DCO1_19     @ 19;
    tdc_reg              SET_TDC_DCO1_20     @ 20;
    tdc_reg              SET_TDC_DCO1_21     @ 21;
    tdc_reg              SET_TDC_DCO1_22     @ 22;
    tdc_reg              SET_TDC_DCO1_23     @ 23;
    tdc_reg              SET_TDC_DCO1_24     @ 24;
    tdc_reg              SET_TDC_DCO1_25     @ 25;
    tdc_reg              SET_TDC_DCO1_26     @ 26;
    tdc_reg              SET_TDC_DCO1_27     @ 27;
    tdc_reg              SET_TDC_DCO1_28     @ 28;
    tdc_reg              SET_TDC_DCO1_29     @ 29;
    tdc_reg              SET_TDC_DCO1_30     @ 30;
    tdc_reg              SET_TDC_DCO1_31     @ 31;
    tdc_reg              SET_TDC_DCO1_32     @ 32;
    tdc_reg              SET_TDC_DCO1_33     @ 33;
    tdc_reg              SET_TDC_DCO1_34     @ 34;
    tdc_reg              SET_TDC_DCO1_35     @ 35;
    tdc_reg              SET_TDC_DCO1_36     @ 36;
    tdc_reg              SET_TDC_DCO1_37     @ 37;
    tdc_reg              SET_TDC_DCO1_38     @ 38;
    tdc_reg              SET_TDC_DCO1_39     @ 39;
    tdc_reg              SET_TDC_DCO1_40     @ 40;
    tdc_reg              SET_TDC_DCO1_41     @ 41;
    tdc_reg              SET_TDC_DCO1_42     @ 42;
    tdc_reg              SET_TDC_DCO1_43     @ 43;
    tdc_reg              SET_TDC_DCO1_44     @ 44;
    tdc_reg              SET_TDC_DCO1_45     @ 45;
    tdc_reg              SET_TDC_DCO1_46     @ 46;
    tdc_reg              SET_TDC_DCO1_47     @ 47;
    tdc_reg              SET_TDC_DCO1_48     @ 48;
    tdc_reg              SET_TDC_DCO1_49     @ 49;
    tdc_reg              SET_TDC_DCO1_50     @ 50;
    tdc_reg              SET_TDC_DCO1_51     @ 51;
    tdc_reg              SET_TDC_DCO1_52     @ 52;
    tdc_reg              SET_TDC_DCO1_53     @ 53;
    tdc_reg              SET_TDC_DCO1_54     @ 54;
    tdc_reg              SET_TDC_DCO1_55     @ 55;
    tdc_reg              SET_TDC_DCO1_56     @ 56;
    tdc_reg              SET_TDC_DCO1_57     @ 57;
    tdc_reg              SET_TDC_DCO1_58     @ 58;
    tdc_reg              SET_TDC_DCO1_59     @ 59;
    tdc_reg              SET_TDC_DCO1_60     @ 60;
    tdc_reg              SET_TDC_DCO1_61     @ 61;
    tdc_reg              SET_TDC_DCO1_62     @ 62;
    tdc_reg              SET_TDC_DCO1_63     @ 63;

    // Instantiate TDC Control All
    tdc_ctrl_reg         SET_TDC_CTRL_ALL    @ 64;

    // Instantiate TDC TP Selector
    tdc_tpsel_reg        SET_TDC_TPSEL_0     @ 65;
    tdc_tpsel_reg        SET_TDC_TPSEL_1     @ 66;

    // Instantiate Global setting configurations
    afe_tdc_global_reg   SET_AFE_TDC_GLOBAL  @ 67;
    afe_global0_reg      SET_AFE_GLOBAL_0    @ 68;
    afe_global1_reg      SET_AFE_GLOBAL_1    @ 69;

    // Instantiate DAC Voltage configurations
    dac_vth_h_reg        SET_DAC_VTH_H       @ 70;
    dac_vth_l_reg        SET_DAC_VTH_L       @ 71;
    dac_vinj_h_reg       SET_DAC_VINJ_H      @ 72;
    dac_vinj_l_reg       SET_DAC_VINJ_L      @ 73;
    dac_vldo_reg         SET_DAC_VLDO        @ 74;
    dac_vfb_reg          SET_DAC_VFB         @ 75;

    // Instantiate FTDAC registers
    ftdac_reg            SET_FTFAC_01_00     @ 76;
    ftdac_reg            SET_FTFAC_03_02     @ 77;
    ftdac_reg            SET_FTFAC_05_04     @ 78;
    ftdac_reg            SET_FTFAC_07_06     @ 79;
    ftdac_reg            SET_FTFAC_09_08     @ 80;
    ftdac_reg            SET_FTFAC_11_10     @ 81;
    ftdac_reg            SET_FTFAC_13_12     @ 82;
    ftdac_reg            SET_FTFAC_15_14     @ 83;
    ftdac_reg            SET_FTFAC_17_16     @ 84;
    ftdac_reg            SET_FTFAC_19_18     @ 85;
    ftdac_reg            SET_FTFAC_21_20     @ 86;
    ftdac_reg            SET_FTFAC_23_22     @ 87;
    ftdac_reg            SET_FTFAC_25_24     @ 88;
    ftdac_reg            SET_FTFAC_27_26     @ 89;
    ftdac_reg            SET_FTFAC_29_28     @ 90;
    ftdac_reg            SET_FTFAC_31_30     @ 91;
    ftdac_reg            SET_FTFAC_33_32     @ 92;
    ftdac_reg            SET_FTFAC_35_34     @ 93;
    ftdac_reg            SET_FTFAC_37_36     @ 94;
    ftdac_reg            SET_FTFAC_39_38     @ 95;
    ftdac_reg            SET_FTFAC_41_40     @ 96;
    ftdac_reg            SET_FTFAC_43_42     @ 97;
    ftdac_reg            SET_FTFAC_45_44     @ 98;
    ftdac_reg            SET_FTFAC_47_46     @ 99;
    ftdac_reg            SET_FTFAC_49_48     @ 100;
    ftdac_reg            SET_FTFAC_51_50     @ 101;
    ftdac_reg            SET_FTFAC_53_52     @ 102;
    ftdac_reg            SET_FTFAC_55_54     @ 103;
    ftdac_reg            SET_FTFAC_57_56     @ 104;
    ftdac_reg            SET_FTFAC_59_58     @ 105;
    ftdac_reg            SET_FTFAC_61_60     @ 106;
    ftdac_reg            SET_FTFAC_63_62     @ 107;
    
    // Instantiate command register
    cmd_reg              COMMAND             @ 112;
};
